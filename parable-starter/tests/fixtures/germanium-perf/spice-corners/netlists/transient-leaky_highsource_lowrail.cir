Positive-ground PNP reduced germanium circuit
Vbattery supply 0 -6
Vinput source 0 SIN(0 0.050000000000000003 997)
Rsource source intermediate 100000
Cin intermediate b1 2.2u
Xq1 c1 b1 0 measured beta=229.59999999999999 leak=7.5459999999999999e-05
Xq2 c2 c1 e2 measured beta=229.59999999999999
Rcollector1 c1 supply 33k
Rfeedback b1 e2 100000
Rft e2 wiper 199.99999999999994
Rfb wiper 0 800
Cbypass wiper 0 20u
Cbc1 b1 c1 100p
Cbc2 c1 c2 100p
Rcollector2 c2 tap 8.2k
Rsupplytap tap supply 470
Cout tap volume 10n
RvolumeTop volume jack 250k
RvolumeBottom jack 0 250k
Rload jack 0 1Meg
.nodeset v(b1)=-.073 v(c1)=-.21 v(e2)=-.16 v(c2)=-7.55

.subckt measured c b e params: beta=229.6 leak=7.546u
Bbe e b I={20.66u/beta*(exp(v(e,b)/(1.133*0.0255))-1)+2.190u*(exp(v(e,b)/(1.796*0.0255))-1)}
Bbc c b I={20.66u/14.66*(exp(v(c,b)/(1.140*0.0255))-1)+leak*(exp(v(c,b)/(1.364*0.0255))-1)}
Btransport e c I={2*(1-v(e,b)/88.28-v(c,b)/19.68)/(1+sqrt(1+4*(20.66u*(exp(v(e,b)/(1.133*0.0255))-1)/0.463+20.66u*(exp(v(c,b)/(1.140*0.0255))-1)/0.2415)))*(20.66u*(exp(v(e,b)/(1.133*0.0255))-1)-20.66u*(exp(v(c,b)/(1.140*0.0255))-1))}
.ends

.options reltol=1e-8 abstol=1e-13 vntol=1e-10 gmin=1e-14
.temp 26.85
.control
set noaskquit
set wr_singlescale
set wr_vecnames
tran 0.25u 0.012 0 0.25u
wrdata transient-leaky_highsource_lowrail.txt v(b1) v(c1) v(e2) v(c2) v(tap) v(jack) i(Vinput)
quit
.endc
.end
