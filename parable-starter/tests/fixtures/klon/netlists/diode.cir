Independent generic nominal Ge diode
Vtest d 0 0
Dtest d 0 Ge
.model Ge D(IS=600n N=1.5 EG=.67 CJO=0 TT=0 TNOM=26.85)

.options reltol=1e-8 abstol=1e-13 vntol=1e-10 gmin=1e-14
.temp 26.85
.control
set noaskquit
set wr_singlescale
set wr_vecnames
option reltol=1e-9 abstol=1e-15 vntol=1e-12
dc Vtest -.5 .5 .01
wrdata diode.txt i(Vtest)
quit
.endc
.end
