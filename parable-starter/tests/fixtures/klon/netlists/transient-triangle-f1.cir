Independent S698 Chittum April15 2009 effect-on; fixed nominal pump rails
V9 p9 0 9
.global p9
V18 p18 0 16.2
VN neg 0 -8.6
R29 p9 ref 27k
R30 ref 0 27k
C18 ref 0 47u
Vsrc disconnected 0 0 AC 1
Btriangle src 0 V=0.29999999999999999*2/pi*asin(sin(2*pi*1000*time))
Rsource src jackin 1k
R1 jackin ci 10k
C1 ci ip 100n
R2 ip ref 1meg
XU1A ip buf buf amp LO=-3 HI=3
C2 buf bh 4.7u
R3 bh 0 100k
R4 bh byp 560
C3 buf pre 100n
R5 pre cu 5.1k
C4 pre cu 68n
R6 pre dp 10k
C5 pre dp 68n
R7 pre ff1 1.5k
C16 ff1 0 1u
R19 ff1 sm 15k
R8 cu ref 1.5k
C6 cu c6low 390n
R9 c6low ref 1k
RP1Btop dp ref 50000
RP1Bbottom pb ref 50000
R10 pb fbn 2k
R11 fbn dm 15k
C7 fbn dm 82n
R12 dm dout 422k
C8 dm dout 390p
XU1B dp dm dout amp LO=-3 HI=3
C9 dout c9r 1u
R13 c9r clip 1k
D2 0 clip Ge
D3 clip 0 Ge
C10 clip pc 1u
R16 pc sm 47k
C11 pc c11r 2.2n
R15 c11r cw 22k
R17 sm cw 27k
C12 sm c12r 27n
R18 c12r cw 12k
RP1Atop cu track 50000
RP1Abottom track ref 50000
RP1Acontact track cw 100000
R20 sm so 392k
C13 sm so 820p
XU2A ref sm so amp LO=-11.6 HI=10.2
R21 so p2b 1.8k
R22 so tm 100k
R23 p2t tout 4.7k
R241 tm tout 100k
RP2top p2t p2w 5000
RP2bottom p2w p2b 5000
C14 p2w tm 3.9n
XU2B ref tm tout amp LO=-11.6 HI=10.2
C15 tout co 4.7u
R25 co lev 560
RP3top lev out 5000
RP3bottom out 0 5000
R26 byp out 68k
R27 lev out 68k
R28 out 0 100k
Rload out 0 1meg
.model Ge D(IS=600n N=1.5 EG=.67 CJO=0 TT=0 TNOM=26.85)
.subckt amp p n o params: LO=-3 HI=3
Rin p n 1e12
Bstate 0 u I=1e-6*(min(max(94.2477796076938*(200000*v(p,n)-v(u)),-13e6),13e6)-1e10*(v(u)-min(max(v(u),LO),HI)))
Cstate u 0 1u
Ecenter center 0 p9 0 .5
Edrive internal center u 0 1
Rout internal o 50
.ends

.ic v(xu1a.u)=0 v(xu1a.internal)=4.5 v(xu1b.u)=0 v(xu1b.internal)=4.5 v(xu2a.u)=0 v(xu2a.internal)=4.5 v(xu2b.u)=0 v(xu2b.internal)=4.5
.ic v(ref)=4.5 v(ip)=4.5 v(buf)=4.5 v(pre)=4.5 v(cu)=4.5 v(dp)=4.5 v(ff1)=4.5 v(sm)=4.5 v(c6low)=4.5 v(pb)=4.5 v(fbn)=4.5 v(dm)=4.5 v(dout)=4.5 v(pc)=4.5 v(c11r)=4.5 v(cw)=4.5 v(c12r)=4.5 v(track)=4.5 v(so)=4.5 v(tm)=4.5 v(p2t)=4.5 v(p2b)=4.5 v(p2w)=4.5 v(tout)=4.5

.options reltol=1e-8 abstol=1e-13 vntol=1e-10 gmin=1e-14
.temp 26.85
.control
set noaskquit
set wr_singlescale
set wr_vecnames
option reltol=1e-5 abstol=1e-10 vntol=1e-7
option method=gear maxord=2
tran 1u .06 0 .5u uic
wrdata transient-triangle-f1.txt v(ip) v(buf) v(pre) v(cu) v(dp) v(fbn) v(dm) v(dout) v(clip) v(pc) v(cw) v(ff1) v(sm) v(so) v(tm) v(tout) v(lev) v(bh) v(byp) v(out) v(ref) v(xu1a.u) v(xu1b.u) v(xu2a.u) v(xu2b.u) v(c11r) v(c12r)
quit
.endc
.end
