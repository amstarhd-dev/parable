Independent antiparallel pair
Vtest d 0 0
Dpos d 0 pair
Dneg 0 d pair
.model silicon NPN(IS=1e-14 BF=300 BR=4 NF=1 NR=1 VAF=0 VAR=0 IKF=0 IKR=0 CJE=0 CJC=0 TF=0 TR=0 TNOM=26.85)
.model pair D(IS=2.52n N=1.752 RS=0 CJO=0 TT=0 TNOM=26.85)

.options reltol=1e-8 abstol=1e-13 vntol=1e-10 gmin=1e-14
.temp 26.85
.control
set noaskquit
set wr_singlescale
set wr_vecnames
dc Vtest -0.7 0.7 0.05
wrdata diodes.txt v(d) i(Vtest)
quit
.endc
.end
