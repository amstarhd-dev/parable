Positive-ground PNP reduced germanium circuit
Vbattery supply 0 -9

Rsource source intermediate 101
Cin intermediate b1 2.2u
Xq1 c1 b1 0 measured leak=7.5460000000000003e-06
Xq2 c2 c1 e2 measured
Rcollector1 c1 supply 33k
Rfeedback b1 e2 100000
Rft e2 wiper 500
Rfb wiper 0 500
Cbypass wiper 0 20u
Cbc1 b1 c1 100p
Cbc2 c1 c2 100p
Rcollector2 c2 tap 8.2k
Rsupplytap tap supply 470
Cout tap volume 10n
RvolumeTop volume jack 250k
RvolumeBottom jack 0 250k
Rload jack 0 1Meg
.nodeset v(b1)=-.073 v(c1)=-.21 v(e2)=-.16 v(c2)=-7.55

.subckt measured c b e params: beta=229.6 leak=7.546u
Bbe e b I={20.66u/beta*(exp(v(e,b)/(1.133*0.0255))-1)+2.190u*(exp(v(e,b)/(1.796*0.0255))-1)}
Bbc c b I={20.66u/14.66*(exp(v(c,b)/(1.140*0.0255))-1)+leak*(exp(v(c,b)/(1.364*0.0255))-1)}
Btransport e c I={2*(1-v(e,b)/88.28-v(c,b)/19.68)/(1+sqrt(1+4*(20.66u*(exp(v(e,b)/(1.133*0.0255))-1)/0.463+20.66u*(exp(v(c,b)/(1.140*0.0255))-1)/0.2415)))*(20.66u*(exp(v(e,b)/(1.133*0.0255))-1)-20.66u*(exp(v(c,b)/(1.140*0.0255))-1))}
.ends

Vprobe drive source 0
Bstim stimulus 0 V={0.050000000000000003*sin(2*pi*997*time)}
Bisense sensor0 0 V={1000*(i(Vprobe)*(1+0.0001)+1.0000000000000001e-09)}
Rsen sensor0 sensor1 1000
Csen sensor1 0 9.9999999999999991e-11
Esen sensorbuf 0 sensor1 0 1
Vclk clk 0 PULSE(0 1 0 1n 1n 20n 5.2083333333333332e-06)
Sadc sensorbuf ihold clk 0 sample
Cadc ihold 0 1n
Radc ihold 0 1T
Ssource stimulus uhold clk 0 sample
Csource uhold 0 1n
Rsourcehold uhold 0 1T
.model sample SW(Ron=1 Roff=1e15 Vt=.5 Vh=.1)
Bsum rawcmd 0 V={v(uhold)-0.90000000000000002*(3.0517578125e-05*min(32767,max(-32768,floor((v(ihold))/3.0517578125e-05+0.5))))}
Btx tx 0 V={v(rawcmd)}
Ttransport tx 0 delayed 0 Z0=1 TD=9.9999999999999995e-07
Rterm delayed 0 1
Bdac drvcmd 0 V={(3.0517578125e-05*min(32767,max(-32768,floor((v(delayed))/3.0517578125e-05+0.5))))}
Rsettle drvcmd settled 1000
Csettle settled 0 1.9999999999999998e-10
Edrive drive 0 settled 0 1

.options reltol=1e-8 abstol=1e-13 vntol=1e-10 gmin=1e-14
.temp 26.85
.control
set noaskquit
set wr_singlescale
set wr_vecnames
tran 0.25u 0.012 0 0.25u
wrdata healthy_mid-fast_192k.txt v(b1) v(c1) v(e2) v(c2) v(tap) v(jack) i(Vprobe) v(rawcmd) v(drvcmd)
quit
.endc
.end
