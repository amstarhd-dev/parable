ElectroSmash TS808 true-bypass drawing, effect-on only, explicit nominal devices
Vcc rail 0 9
Vref ref 0 4.5
Bsrc source 0 V={0.29999999999999999*(2/PI)*asin(sin(2*PI*1000*time))}
Rsource source in 1k
C1 in ci 20n
R1 ci b1 1k
R2 ref b1 510k
Q1 rail b1 e1 silicon
R3 e1 0 10k
C2 e1 plus 1u
R5 plus ref 10k
R4 cr 0 4.7k
C3 minus cr 47n
R6 minus o1 142371.99881577841
C4 minus o1 51p
D1 minus o1 diode
D2 o1 minus diode
R8 o1 tp 1k
C5 tp 0 220n
R9 tp ref 10k
R10 cc 0 220
C6 tw cc 220n
R11 tm o2 1k
Rtone1 tp tw 10000
Rtone2 tw tm 10000
C7 o2 cp 1u
R12 cp leveltop 1k
Rlevel1 leveltop lw 50000
Rlevel2 lw 0 50000
C8 lw b3 100n
R13 ref b3 510k
Q3 rail b3 e3 silicon
R14 e3 0 10k
RB e3 ob 100
C9 ob jack 10u
RC jack 0 10k
Rload jack 0 1Meg
.model silicon NPN(IS=1e-14 BF=350 BR=4 VAF=0 VAR=0 CJE=0 CJC=0 TF=0 TR=0 TNOM=26.85)
.model diode D(IS=2.52n N=1.752 RS=0 CJO=0 TT=0 TNOM=26.85)
Rdiff1 plus minus 5Meg
Cpole1 u1 0 1n
Bamp1 0 u1 I={1e-9*(max(-1e6,min(1e6,188.4955592153876*(1e5*v(plus,minus)-v(u1))))-1e9*(v(u1)-max(-3,min(3,v(u1)))) )}
Eamp1 drive1 ref u1 0 1
Rout1 drive1 o1 75
Rdiff2 tp tm 5Meg
Cpole2 u2 0 1n
Bamp2 0 u2 I={1e-9*(max(-1e6,min(1e6,188.4955592153876*(1e5*v(tp,tm)-v(u2))))-1e9*(v(u2)-max(-3,min(3,v(u2)))) )}
Eamp2 drive2 ref u2 0 1
Rout2 drive2 o2 75

.save all @d1[id] @d2[id]

.options reltol=1e-8 abstol=1e-13 vntol=1e-10 gmin=1e-14
.temp 26.85
.control
set noaskquit
set wr_singlescale
set wr_vecnames
option method=gear maxord=2 reltol=1e-5 abstol=1e-10 vntol=1e-7
tran 1u .12 0 4.9999999999999998e-07
let d2current=@d2[id]
wrdata transient-0-triangle-5e-07.txt v(b1) v(e1) v(plus) v(minus) v(o1) v(tp) v(tm) v(o2) v(leveltop) v(b3) v(e3) v(jack) v(u1) v(u2) v(in,ci) v(e1,plus) v(minus,cr) v(minus,o1) v(tp) v(tw,cc) v(o2,cp) v(lw,b3) v(ob,jack) @d1[id] d2current v(source)
quit
.endc
.end
