SF017 independent reduced reference
Vrail va 0 9
R11 va vc 1k
R12 vc vd 56k
R13 vd 0 33k
R1 vd b 220k
R3 vc x 5600
R2 e f 5.6k
Rtrim f 0 68
R7 va ep 4.7k
R6 y 0 5.6k
Q1 x b e N
Q2 y x ep P
Ileak ep y 50u
Vin in 0 SIN(0 0.0001 1000)
Rsource in ci 1k
C2 ci b 1u
C3 b 0 330p
C4 e f 1
C6 y fb 1
R8_GAIN f fb 30600.0
C7 f fb 1n
C8 ep va 330n
Rlow ep lc 3500.65
C9 lc va 330u
C11 vc 0 1
C12 vd 0 1
Bbuffer buf 0 V=v(y)-2.80981969036111
Rout buf c10 3933.345000266287
C10 c10 r9 100u
R9 r9 primary 15k
R10 primary 0 33k
Rp primary core 820
Rsecondary core secondary 1070
Rleveltop secondary jack 19999.999999999996
Rlevelbottom jack 0 80000.0
Rexternal jack 0 1meg
Cflux phi 0 1 IC=0
Bflux 0 phi I=v(core)
Bmag core 0 I=v(phi)/20+v(phi)*v(phi)*v(phi)/(20*.008*.008)
.model N NPN(IS=1e-14 BF=400 BR=4 TNOM=26.85)
.model P PNP(IS=1e-9 BF=100 BR=4 TNOM=26.85)
.temp 26.85
.control
set numdgt=15
set wr_singlescale
set wr_vecnames
tran .5u .03 0 .5u
wrdata /workspace/work/sf017-reference/transient.txt v(jack) v(phi)
quit
.endc
.end
